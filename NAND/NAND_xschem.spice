** sch_path: /home/ee431/workspace/NAND/NAND.sch
.subckt NAND A Y VDD GND B
*.PININFO A:I Y:O VDD:B GND:B B:I
XM4 Y A VDD VDD sky130_fd_pr__pfet_01v8 L=0.5 W=2 nf=1 m=1
XM3 Y B VDD VDD sky130_fd_pr__pfet_01v8 L=0.5 W=2 nf=1 m=1
XM2 Y B net1 GND sky130_fd_pr__nfet_01v8 L=0.5 W=2 nf=1 m=1
XM1 net1 A GND GND sky130_fd_pr__nfet_01v8 L=0.5 W=2 nf=1 m=1
.ends
.end
