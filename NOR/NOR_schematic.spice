** sch_path: /home/ee431/workspace/NOR/NOR.sch
.subckt NOR A B GND VDD Y
*.PININFO A:I B:I GND:B VDD:B Y:O
XM1 Y A GND GND sky130_fd_pr__nfet_01v8 L=0.5 W=1 nf=1 m=1
XM2 Y B GND GND sky130_fd_pr__nfet_01v8 L=0.5 W=1 nf=1 m=1
XM3 Y B net1 VDD sky130_fd_pr__pfet_01v8 L=0.5 W=4 nf=1 m=1
XM4 net1 A VDD VDD sky130_fd_pr__pfet_01v8 L=0.5 W=4 nf=1 m=1
.ends
.end
